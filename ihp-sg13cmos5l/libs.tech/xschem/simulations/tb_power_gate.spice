** sch_path: /home/designer/shared/hm-openpdk-library/ihp-sg13cmos5l/libs.tech/xschem/tests/tb_power_gate.sch
**.subckt tb_power_gate
x1 vdd net1 ctrl GND power_gate
V1 vdd GND 1.2
.save i(v1)
V2 ctrl GND PULSE(0 1.8 50n 0.5n 0.5n 99.5n 4u)
C1 vdd_dut GND 75p m=1
Vdut net1 vdd_dut 0
.save i(vdut)
**** begin user architecture code

.lib cornerMOSlv.lib mos_tt
*.lib cornerCAP.lib cap_typ

.param mc_mm_switch=0
.control
save all
tran 50p 5u
plot vdd_dut
plot vdd_dut x1.ctrl_n ctrl xlimit 50n 60n
*quit 0
.endc
.end

**** end user architecture code
**.ends

* expanding   symbol:  /home/designer/shared/hm-openpdk-library/ihp-sg13cmos5l/libs.tech/xschem/hm_analog/power_gate.sym # of
*+ pins=4
** sym_path: /home/designer/shared/hm-openpdk-library/ihp-sg13cmos5l/libs.tech/xschem/hm_analog/power_gate.sym
** sch_path: /home/designer/shared/hm-openpdk-library/ihp-sg13cmos5l/libs.tech/xschem/hm_analog/power_gate.sch
.subckt power_gate VPWR GPWR ctrl VGND
*.ipin ctrl
*.iopin VPWR
*.iopin VGND
*.iopin GPWR
XM1 ctrl_n ctrl VGND VGND sg13_lv_nmos w=2.6u l=0.13u ng=1 m=1 mm_ok=1
XM2 ctrl_n ctrl VPWR VPWR sg13_lv_pmos w=4.44u l=0.13u ng=1 m=1 mm_ok=1
XM3 GPWR ctrl_n VPWR VPWR sg13_lv_pmos w=2175u l=0.13u ng=290 m=1 mm_ok=1
x1 VGND GPWR ctrl_n dischg
.ends

* expanding   symbol:  /home/designer/shared/hm-openpdk-library/ihp-sg13cmos5l/libs.tech/xschem/hm_analog/dischg.sym # of pins=3
** sym_path: /home/designer/shared/hm-openpdk-library/ihp-sg13cmos5l/libs.tech/xschem/hm_analog/dischg.sym
** sch_path: /home/designer/shared/hm-openpdk-library/ihp-sg13cmos5l/libs.tech/xschem/hm_analog/dischg.sch
.subckt dischg VGND GPWR gate
*.iopin GPWR
*.iopin VGND
*.ipin gate
XM1 GPWR gate net6 GPWR sg13_lv_nmos w=0.50u l=0.65u ng=1 m=1 mm_ok=1
XM2 net6 gate net5 net6 sg13_lv_nmos w=0.50u l=0.65u ng=1 m=1 mm_ok=1
XM3 net5 gate net4 net5 sg13_lv_nmos w=0.50u l=0.65u ng=1 m=1 mm_ok=1
XM4 net4 gate VGND net4 sg13_lv_nmos w=0.50u l=0.65u ng=1 m=1 mm_ok=1
XM5 GPWR gate net3 GPWR sg13_lv_nmos w=0.50u l=0.65u ng=1 m=1 mm_ok=1
XM6 net3 gate net2 net3 sg13_lv_nmos w=0.50u l=0.65u ng=1 m=1 mm_ok=1
XM7 net2 gate net1 net2 sg13_lv_nmos w=0.50u l=0.65u ng=1 m=1 mm_ok=1
XM8 net1 gate VGND net1 sg13_lv_nmos w=0.50u l=0.65u ng=1 m=1 mm_ok=1
.ends

.GLOBAL GND
.end
