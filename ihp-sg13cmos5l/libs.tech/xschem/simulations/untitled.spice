** sch_path: /home/designer/shared/hm-openpdk-library/ihp-sg13cmos5l/libs.tech/xschem/untitled.sch
**.subckt untitled VGND GPWR gate
*.iopin GPWR
*.iopin VGND
*.ipin gate
XM1 GPWR gate net6 GPWR sg13_lv_nmos w=0.50u l=0.65u ng=1 m=1 mm_ok=1
XM2 net6 gate net5 net7 sg13_lv_nmos w=0.50u l=0.65u ng=1 m=1 mm_ok=1
XM3 net8 net9 net10 net11 sg13_lv_nmos w=0.50u l=0.65u ng=1 m=1 mm_ok=1
XM4 net4 gate VGND net12 sg13_lv_nmos w=0.50u l=0.65u ng=1 m=1 mm_ok=1
**.ends
.end
