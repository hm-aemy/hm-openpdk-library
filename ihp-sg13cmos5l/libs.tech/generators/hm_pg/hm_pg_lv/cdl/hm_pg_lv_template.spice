.subckt hm_pg_lv_{{WIDTH}}x{{HEIGHT}} VPWR GPWR VGND CTRL
M1 ctrl_n ctrl VGND VGND sg13_lv_nmos w={{invNmosW}}u l={{invNmosL}}u ng=1 m=1 mm_ok=1
M2 ctrl_n ctrl VPWR VPWR sg13_lv_pmos w={{invPmosW}}u l={{invPmosL}}u ng=1 m=1 mm_ok=1
M3 GPWR ctrl_n VPWR VPWR sg13_lv_pmos w={{width}}u l={{length}}u ng={{ng}} m={{m}} mm_ok=1
x1 VGND GPWR ctrl_n dischg
.ends

.subckt dischg VGND GPWR gate
M1 GPWR gate net1 VGND sg13_lv_nmos w={{dischW}}u l={{dischL}}u ng=1 m=1 mm_ok=1
M2 net1 gate net2 VGND sg13_lv_nmos w={{dischW}}u l={{dischL}}u ng=1 m=1 mm_ok=1
M3 net2 gate net3 VGND sg13_lv_nmos w={{dischW}}u l={{dischL}}u ng=1 m=1 mm_ok=1
M4 net3 gate net4 VGND sg13_lv_nmos w={{dischW}}u l={{dischL}}u ng=1 m=1 mm_ok=1
M5 net4 gate net5 VGND sg13_lv_nmos w={{dischW}}u l={{dischL}}u ng=1 m=1 mm_ok=1
M6 net5 gate net6 VGND sg13_lv_nmos w={{dischW}}u l={{dischL}}u ng=1 m=1 mm_ok=1
M7 net6 gate net7 VGND sg13_lv_nmos w={{dischW}}u l={{dischL}}u ng=1 m=1 mm_ok=1
M8 net7 gate VGND VGND sg13_lv_nmos w={{dischW}}u l={{dischL}}u ng=1 m=1 mm_ok=1

M9 GPWR gate net8 VGND sg13_lv_nmos w={{dischW}}u l={{dischL}}u ng=1 m=1 mm_ok=1
M10 net8 gate net9 VGND sg13_lv_nmos w={{dischW}}u l={{dischL}}u ng=1 m=1 mm_ok=1
M11 net9 gate net10 VGND sg13_lv_nmos w={{dischW}}u l={{dischL}}u ng=1 m=1 mm_ok=1
M12 net10 gate net11 VGND sg13_lv_nmos w={{dischW}}u l={{dischL}}u ng=1 m=1 mm_ok=1
M13 net11 gate net12 VGND sg13_lv_nmos w={{dischW}}u l={{dischL}}u ng=1 m=1 mm_ok=1
M14 net12 gate net13 VGND sg13_lv_nmos w={{dischW}}u l={{dischL}}u ng=1 m=1 mm_ok=1
M15 net13 gate net14 VGND sg13_lv_nmos w={{dischW}}u l={{dischL}}u ng=1 m=1 mm_ok=1
M16 net14 gate VGND VGND sg13_lv_nmos w={{dischW}}u l={{dischL}}u ng=1 m=1 mm_ok=1
.ends

.end
